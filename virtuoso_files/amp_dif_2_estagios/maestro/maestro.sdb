ADE simulation setup
Run mode: Single Run, Sweeps and Corners
Tests:
  joaoPedroBuzatti_amp_dif_2_estagios_1: joaoPedroBuzatti/amp_dif_2_estagios/schematic, simulator spectre
