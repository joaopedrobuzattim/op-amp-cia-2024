ADE simulation setup
Test joaoPedroBuzatti_amp_dif_2_estagios_1: joaoPedroBuzatti/amp_dif_2_estagios/schematic, simulator spectre
  Models: /home/tools/design_kits/cadence/gpdk045_v6/gpdk045_v_6_0/gpdk045/../models/spectre/gpdk045.scs[mc]
  Temperature: 27
Run mode: Single Run, Sweeps and Corners
